# Ansys Electronics Desktop project, version 2025.2
materials:
  vacuum: permittivity=1
  FR4_epoxy: permittivity=4.4 dielectric_loss_tangent=0.02

design Bowtie_ATK (HFSS, HFSS Hybrid Terminal Network, model units cm)
options: Allow_Material_Override Save_Adaptive_support_files open_region{BoundaryType=0 OpFreq=0.9GHz}
variables:
  # --Antenna Dimensions
  Inner_Width = 0.27cm
  Outer_Width = 4.64cm
  Arm_Length = 5.15cm
  Port_Gap_Width = 0.27cm
  # --Substrate Dimensions
  subH = 0.1575cm
  subX = 17cm
  subY = 17cm
  Cut1 = 200mm
  Cut2 = 200mm
  Nose = 10mm
geometry:
  sub [FR4_epoxy] = box(corner=(-subX/2, -subY/2, 0cm), size=(subX, subY, -subH))
  NewObject_ZQ1WRL = polyline((-Inner_Width/2.0, Port_Gap_Width/2.0, 0) (Inner_Width/2.0, Port_Gap_Width/2.0, 0cm))
  arm = polyline((-Outer_Width/2.0, Port_Gap_Width/2.0+Arm_Length, 0cm) (Outer_Width/2.0, Port_Gap_Width/2.0+Arm_Length, 0cm))
  arm.connect(NewObject_ZQ1WRL)
  arm1 = arm.duplicate_around_axis(axis=Z, angle=180deg, total=2)
  port1 = rectangle(corner=(-Inner_Width/2, -Port_Gap_Width/2, 0cm), x_size=Inner_Width, y_size=Port_Gap_Width)
  RadiatingSurface [vacuum] = region(absolute_offset=11.111111cm on all sides)
  Rectangle1 = rectangle(corner=(-Outer_Width/4-Cut1, -Cut2/2, 0cm), x_size=Cut1, y_size=Cut2)
  Rectangle2 = rectangle(corner=(Outer_Width/4, -Cut2/2, 0cm), x_size=Cut1, y_size=Cut2)
  Rectangle1_1 = Rectangle1.copy()
  Rectangle2_1 = Rectangle2.copy()
  arm.subtract(Rectangle1_1, Rectangle2_1)
  arm1.subtract(Rectangle1, Rectangle2)
boundaries and excitations:
  antennaMetal: Perfect E Objects=[arm, arm1]
  AutoOpen1: Radiation Objects=RadiatingSurface
  arm_T1: Terminal port=1 Edges=arm.edge(at (0, 0.135, 0)) TerminalResistance=50ohm
  1: Lumped Port Faces=port1.face LumpedPortType=Terminal Impedance=50ohm
  reference conductors: arm1
setups:
  ATK_Solution: HfssDriven MultipleAdaptiveFreqsSetup{AdaptAt{Frequency=0.8GHz Delta=0.02} AdaptAt{Frequency=0.9GHz Delta=0.02} AdaptAt{Frequency=1GHz Delta=0.02}} MaximumPasses=15 MinimumPasses=1 MinimumConvergedPasses=1 PercentRefinement=30 BasisOrder=1 PortAccuracy=2 DrivenSolverType="Direct Solver" IESolverType=ACA
    sweep FF_Sweep: 0.5GHz to 1.5GHz, 45 points; Type=Discrete SaveFields
    sweep SParam_Sweep: 0.5GHz to 1.5GHz, 100 points; Type=Interpolating InterpTolerance=0.5 InterpMaxSolns=250 PassivityErrorTolerance=0.0001
source amplitudes:
  1:1: 1V 0deg
radiation setups:
  3D: Infinite Sphere Theta=0deg..180deg step 2deg Phi=-180deg..180deg step 2deg
  Elevation: Infinite Sphere Theta=-180deg..180deg step 1deg Phi=0deg..90deg step 90deg
  Azimuth: Infinite Sphere Theta=90deg..90deg step 0deg Phi=-180deg..180deg step 1deg
  ATK_2D: Infinite Sphere Theta=-180deg..180deg step 1deg Phi=0deg..90deg step 90deg
  ATK_3D: Infinite Sphere Theta=-180deg..180deg step 2deg Phi=0deg..180deg step 5deg
reports:
  ff_3D_GainTotal: dB(GainTotal) vs Phi, Theta on ATK_Solution : LastAdaptive, ATK_3D [Freq=1e+09]
  ff_2D_GainTotal_1GHz: dB(GainTotal) vs Theta on ATK_Solution : LastAdaptive, ATK_2D [Phi=all Freq=1e+09]
  ff_2D_GainTotal_Stacked: dB(GainTotal) vs Theta on ATK_Solution : FF_Sweep, ATK_2D [Phi=all Freq=all]
  Return Loss: dB(St11) vs Freq on ATK_Solution : SParam_Sweep; markers m1 at 0.88383838GHz, m2 at 0.96464646GHz, m3 at 1.0555556GHz
  Input Impedance: St11, St22 on ATK_Solution : SParam_Sweep [Freq=all]
  Gain_Peak: GainTotal vs Freq on ATK_Solution : FF_Sweep, Elevation [Phi=0deg Theta=0deg]
  ff_2D_GainTotal_0,9GHz: dB(GainTotal) vs Theta on ATK_Solution : LastAdaptive, ATK_2D [Phi=all Freq=0.9GHz]
  ff_2D_GainTotal_0,8GHz: dB(GainTotal) vs Theta on ATK_Solution : LastAdaptive, ATK_2D [Phi=all Freq=0.8GHz]
