# Ansys Electronics Desktop project, version 2025.2
materials:
  vacuum: permittivity=1
  FR4_epoxy: permittivity=4.4 dielectric_loss_tangent=0.02

design BowtieRounded_ATK (HFSS, HFSS Hybrid Terminal Network, model units cm)
options: Allow_Material_Override Save_Adaptive_support_files open_region{BoundaryType=0 OpFreq=0.9GHz}
variables:
  # --Antenna Dimensions
  Inner_Width = 0.18cm
  Outer_Width = 4.43cm
  Arm_Length = 3.69cm
  Outer_Radius = 2.44cm
  Port_Gap_Width = 0.18cm
  # --Substrate Dimensions
  subH = 0.1575cm
  subX = 15cm
  subY = 15cm
  # --Radiating Surface
  Huygens_dist = 2cm
  Airbox_dist = 9.9931cm
  dis = 150mm
  expan = 270mm
  disMM = 130mm
  D1 = 60mm
  Diametro = 59mm
  subXMM = 180mm
  subYMM = 180mm
  D3 = 10mm
geometry:
  sub [FR4_epoxy] = box(corner=(-subX/2, -subY/2, 0cm), size=(subX, subY, -subH))
  NewObject_WKLM9S = polyline((-Inner_Width/2.0, Port_Gap_Width/2.0, 0) (Inner_Width/2.0, Port_Gap_Width/2.0, 0cm))
  arm = polyline((-Outer_Width/2.0, Port_Gap_Width/2.0+Arm_Length, 0cm) (Outer_Width/2.0, Port_Gap_Width/2.0+Arm_Length, 0cm))
  arm.connect(NewObject_WKLM9S)
  NewObject_9BOWNY = circle(normal=Z, centre=(0cm, if(Outer_Radius>=Outer_Width/2,arm_length-outer_width/2/tan(asin(outer_width/2/outer_radius))+port_gap_width/2 ,arm_length), 0cm), radius=Outer_Radius)
  NewObject_9BOWNY.move(0cm, -Arm_Length-(Port_Gap_Width/2), 0cm)
  NewObject_9BOWNY.split(plane=ZX, keep=PositiveOnly)
  NewObject_9BOWNY.move(0cm, Arm_Length+(Port_Gap_Width/2), 0cm)
  arm.unite(NewObject_9BOWNY)
  arm1 = arm.duplicate_around_axis(axis=Z, angle=180deg, total=2)
  port1 = rectangle(corner=(-Inner_Width/2, -Port_Gap_Width/2, 0cm), x_size=Inner_Width, y_size=Port_Gap_Width)
  HuygensBox [vacuum] = box(corner=(-subX/2 - Huygens_dist, -subY/2 - Huygens_dist, -subH - Huygens_dist - expan/2-10 mm), size=(abs(-subX/2 - subX/2) + 2*Huygens_dist, abs(-subY/2 - subY/2) + 2*Huygens_dist, abs(-subH - 0) + 2*Huygens_dist+expan))
  RadiatingSurface [vacuum] = region(absolute_offset=11.111111cm on all sides)
  Fr4_Reflex [FR4_epoxy] = box(corner=(-subX/2, -subY/2, -dis), size=(subX, subY, -subH))
  Rectangle1 = rectangle(corner=(-subX/2, -subY/2, -dis), x_size=subX, y_size=subY)
  Fr4_MM [FR4_epoxy] = box(corner=(-subXMM/2, -subYMM/2, disMM), size=(subXMM, subYMM, -subH))
  Circle1 = circle(normal=Z, centre=(0, 0, disMM), radius=Diametro/2)
  Circle2 = circle(normal=Z, centre=(0cm, 0cm, disMM), radius=Diametro/2-D3)
  Circle1.subtract(Circle2)
  Circle3 = circle(normal=Z, centre=(D1, 0, disMM), radius=Diametro/2)
  Circle4 = circle(normal=Z, centre=(D1, 0, disMM), radius=Diametro/2-D3)
  Circle3.subtract(Circle4)
  Circle5 = circle(normal=Z, centre=(-D1, 0, disMM), radius=Diametro/2)
  Circle7 = circle(normal=Z, centre=(-D1, 0cm, disMM), radius=Diametro/2-D3)
  Circle5.subtract(Circle7)
  Circle6 = circle(normal=Z, centre=(0, D1, disMM), radius=Diametro/2)
  Circle8 = circle(normal=Z, centre=(0, D1, disMM), radius=Diametro/2-D3)
  Circle6.subtract(Circle8)
  Circle9 = circle(normal=Z, centre=(D1, D1, disMM), radius=Diametro/2)
  Circle13 = circle(normal=Z, centre=(D1, D1, disMM), radius=Diametro/2-D3)
  Circle9.subtract(Circle13)
  Circle10 = circle(normal=Z, centre=(D1, -D1, disMM), radius=Diametro/2)
  Circle14 = circle(normal=Z, centre=(D1, -D1, disMM), radius=Diametro/2-D3)
  Circle10.subtract(Circle14)
  Circle11 = circle(normal=Z, centre=(-D1, D1, disMM), radius=Diametro/2)
  Circle15 = circle(normal=Z, centre=(-D1, D1, disMM), radius=Diametro/2-D3)
  Circle11.subtract(Circle15)
  Circle12 = circle(normal=Z, centre=(-D1, -D1, disMM), radius=Diametro/2)
  Circle16 = circle(normal=Z, centre=(-D1, -D1, disMM), radius=Diametro/2-D3)
  Circle12.subtract(Circle16)
  Circle17 = circle(normal=Z, centre=(0, -D1, disMM), radius=Diametro/2)
  Circle18 = circle(normal=Z, centre=(0, -D1, disMM), radius=Diametro/2-D3)
  Circle17.subtract(Circle18)
boundaries and excitations:
  antennaMetal: Perfect E Objects=[arm, arm1]
  AutoOpen1: Radiation Objects=RadiatingSurface
  Relfex_PE: Perfect E Objects=Rectangle1
  MetaMaterial: Perfect E Objects=[Circle1, Circle3, Circle5, Circle6, Circle9..Circle12, Circle17]
  arm_T1: Terminal port=1 Edges=arm.edge(at (0, 0.09, 0)) TerminalResistance=50ohm
  1: Lumped Port Faces=port1.face LumpedPortType=Terminal Impedance=50ohm
  reference conductors: arm1
mesh:
  HuygensBox_Seed: LengthBased Objects=HuygensBox MaxLength=2.9979cm
setups:
  ATK_Solution: HfssDriven MultipleAdaptiveFreqsSetup{AdaptAt{Frequency=0.8GHz Delta=0.02} AdaptAt{Frequency=0.9GHz Delta=0.02} AdaptAt{Frequency=1GHz Delta=0.02}} MaximumPasses=15 MinimumPasses=1 MinimumConvergedPasses=1 PercentRefinement=30 BasisOrder=1 PortAccuracy=2 DrivenSolverType="Direct Solver" IESolverType=ACA
    sweep FF_Sweep: 0.5GHz to 1.5GHz, 45 points; Type=Discrete SaveFields
    sweep SParam_Sweep: 0.3GHz to 1.3GHz, 100 points; Type=Interpolating InterpTolerance=0.5 InterpMaxSolns=250 PassivityErrorTolerance=0.0001
source amplitudes:
  1:1: 1V 0deg
radiation setups:
  3D: Infinite Sphere Theta=0deg..180deg step 2deg Phi=-180deg..180deg step 2deg
  Elevation: Infinite Sphere Theta=-180deg..180deg step 1deg Phi=0deg..90deg step 90deg
  Azimuth: Infinite Sphere Theta=90deg..90deg step 0deg Phi=-180deg..180deg step 1deg
  ATK_2D: Infinite Sphere Theta=-180deg..180deg step 1deg Phi=0deg..90deg step 90deg
  ATK_3D: Infinite Sphere Theta=-180deg..180deg step 2deg Phi=0deg..180deg step 5deg
reports:
  ff_3D_GainTotal_1Ghz: dB(GainTotal) vs Phi, Theta on ATK_Solution : LastAdaptive, ATK_3D [Freq=1e+09]
  ff_2D_GainTotal_1GHz: dB(GainTotal) vs Theta on ATK_Solution : LastAdaptive, ATK_2D [Phi=all Freq=1e+09]; markers m1 at 0deg, m2 at 32deg, m3 at 47deg
  ff_2D_GainTotal_Stacked: dB(GainTotal) vs Theta on ATK_Solution : FF_Sweep, ATK_2D [Phi=all Freq=all]
  Return Loss: dB(St11) vs Freq on ATK_Solution : SParam_Sweep; markers m1 at 0.80505051GHz, m2 at 1.1080808GHz
  Input Impedance: St11, St22 on ATK_Solution : SParam_Sweep [Freq=all]; markers m1 at 2GHz, m2 at 0.31717172GHz
  ff_3D_GainTotal_0,9GHz: dB(GainTotal) vs Phi, Theta on ATK_Solution : LastAdaptive, ATK_3D [Freq=0.9GHz]
  ff_3D_GainTotal_0,8GHz: dB(GainTotal) vs Phi, Theta on ATK_Solution : LastAdaptive, ATK_3D [Freq=0.8GHz]
  ff_2D_GainTotal_0,9GHz: dB(GainTotal) vs Theta on ATK_Solution : LastAdaptive, ATK_2D [Phi=all Freq=0.9GHz]; markers m1 at 0deg, m2 at 31deg, m3 at 39deg
  ff_2D_GainTotal_0,8GHz: dB(GainTotal) vs Theta on ATK_Solution : LastAdaptive, ATK_2D [Phi=all Freq=0.8GHz]; markers m1 at 0deg, m2 at 31deg, m3 at 39deg
  Gain_Peak: dB(GainTotal) vs Freq on ATK_Solution : FF_Sweep, Elevation [Phi=0deg Theta=0deg]
